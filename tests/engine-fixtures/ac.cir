RC cutoff
V1 in 0 DC 0 AC 1
R1 in out 10000
C1 out 0 1e-7
.options reltol=1e-6
.ac lin 1 159.15494309189532 159.15494309189532
.end
