Equal resistor divider
V1 in 0 10
R1 in out 10000
R2 out 0 10000
.options reltol=1e-6 abstol=1e-12 vntol=1e-9
.op
.end
